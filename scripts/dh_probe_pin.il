(defun dh_probe_pin_main (out_path save_path)
  (let (fp design comps comp pins pin loc via found netname)
    (setq fp (outfile out_path))
    (setq design (axlDBGetDesign))
    (when fp
      (setq comps design->components)
      (fprintf fp "component_count=%L\n" (length comps))
      (setq found nil)
      (foreach comp comps
        (unless found
          (setq pins comp->pins)
          (foreach pin pins
            (unless found
              (when (and pin->definition pin->definition->isThrough)
                (setq found pin)
                (fprintf fp "found_comp=%L\n" comp->name)
                (fprintf fp "found_pin=%L\n" pin)
                (fprintf fp "pin_objType=%L\n" pin->objType)
                (fprintf fp "pin_name=%L\n" pin->name)
                (fprintf fp "pin_xy=%L\n" pin->xy)
                (fprintf fp "pin_definition=%L\n" pin->definition)
                (fprintf fp "pin_definition_name=%L\n" pin->definition->name)
                (fprintf fp "pin_isThrough=%L\n" pin->definition->isThrough)
                (fprintf fp "pin_net=%L\n" pin->net)
                (setq loc pin->xy)
                (setq netname nil)
                (when pin->net
                  (setq netname pin->net->name)
                )
                (setq via (axlDBCreateVia "VIA" loc netname))
                (fprintf fp "created_via=%L\n" via)
              )
            )
          )
        )
      )
      (fprintf fp "found=%L\n" found)
      (close fp)
    )
    (axlCNSDesignModeSet 'Duplicate_Drill_Hole 'on)
    (axlSaveDesign ?design save_path ?noConfirm t)
    t
  )
)
